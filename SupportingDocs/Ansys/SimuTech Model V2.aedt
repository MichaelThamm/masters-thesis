# Ansys Electronics Desktop project, version 2021.2
materials:
  vacuum: permittivity=1
  copper: permeability=0.999991 conductivity=58000000
  cast_aluminum_75C: permeability=1.000021 conductivity=23000000
  iron: permeability=4000 conductivity=10300000
  JFE_Steel_50JN350: core_loss_curve{50Hz (0, 0) (0.5, 0.401) (0.55, 0.481) (0.6, 0.559) (0.65, 0.633) (0.7, 0.717) (0.75, 0.802) (0.8, 0.893) (0.85, 0.989) (0.9, 1.089) (0.95, 1.192) (1, 1.303) (1.05, 1.415) (1.1, 1.547) (1.15, 1.684) (1.2, 1.829) (1.25, 1.986) (1.3, 2.157) (1.35, 2.342) (1.4, 2.551) (1.45, 2.777) (1.5, 2.998) (1.55, 3.241) (1.6, 3.489) (1.65, 3.77) (1.7, 4.035)} core_loss_curve{60Hz (0, 0) (0.5, 0.547) (0.55, 0.629) (0.6, 0.724) (0.65, 0.819) (0.7, 0.923) (0.75, 1.036) (0.8, 1.145) (0.85, 1.263) (0.9, 1.389) (0.95, 1.52) (1, 1.659) (1.05, 1.798) (1.1, 1.967) (1.15, 2.141) (1.2, 2.331) (1.25, 2.531) (1.3, 2.757) (1.35, 2.987) (1.4, 3.229) (1.45, 3.494) (1.5, 3.782) (1.55, 4.081) (1.6, 4.4) (1.65, 4.727) (1.7, 5.07)} core_loss_curve{100Hz (0, 0) (0.06, 0.013) (0.07, 0.0189) (0.08, 0.0254) (0.09, 0.0337) (0.1, 0.0422) (0.15, 0.106) (0.2, 0.19) (0.25, 0.293) (0.3, 0.405) (0.35, 0.532) (0.4, 0.676) (0.45, 0.832) (0.5, 0.987) (0.55, 1.171) (0.6, 1.34) (0.65, 1.536) (0.7, 1.732) (0.75, 1.921) (0.8, 2.157) (0.85, 2.395) (0.9, 2.612) (0.95, 2.9) (1, 3.22) (1.1, 3.82) (1.2, 4.56) (1.3, 5.49) (1.4, 6.53) (1.5, 7.8)} core_loss_curve{200Hz (0, 0) (0.04, 0.0146) (0.05, 0.0238) (0.06, 0.0355) (0.07, 0.05) (0.08, 0.067) (0.09, 0.086) (0.1, 0.108) (0.15, 0.254) (0.2, 0.443) (0.25, 0.695) (0.3, 0.985) (0.35, 1.301) (0.4, 1.655) (0.45, 2.045) (0.5, 2.484) (0.55, 2.937) (0.6, 3.481) (0.65, 3.977) (0.7, 4.532) (0.75, 5.132) (0.8, 5.8) (0.85, 6.467) (0.9, 7.273) (0.95, 8.016) (1, 8.811) (1.1, 10.75) (1.2, 13.1) (1.3, 15.75) (1.4, 18.9) (1.5, 22.5)} core_loss_curve{400Hz (0, 0) (0.02, 0.01) (0.03, 0.024) (0.04, 0.0458) (0.05, 0.074) (0.06, 0.108) (0.07, 0.152) (0.08, 0.2008) (0.09, 0.255) (0.1, 0.3155) (0.15, 0.7159) (0.2, 1.25) (0.25, 1.903) (0.3, 2.682) (0.35, 3.555) (0.4, 4.519) (0.45, 5.583) (0.5, 6.748) (0.55, 8.01) (0.6, 9.367) (0.65, 10.849) (0.7, 12.615) (0.75, 14.284) (0.8, 16.372) (0.85, 18.258) (0.9, 20.654) (0.95, 23.23) (1, 26) (1.1, 32.15) (1.2, 39.97) (1.3, 49.07) (1.4, 59.3) (1.5, 71)} core_loss_curve{1kHz (0, 0) (0.01, 0.0132) (0.02, 0.0555) (0.03, 0.128) (0.04, 0.234) (0.05, 0.368) (0.06, 0.529) (0.07, 0.71) (0.08, 0.92) (0.09, 1.15) (0.1, 1.42) (0.15, 3) (0.2, 5.2) (0.25, 7.88) (0.3, 11.077) (0.35, 14.655) (0.4, 18.611) (0.45, 23.448) (0.5, 28.326) (0.55, 34.301) (0.6, 40.096) (0.65, 47.254) (0.7, 53.976) (0.75, 62.362) (0.8, 71.47) (0.85, 79.695) (0.9, 92)} core_loss_curve{2kHz (0, 0) (0.01, 0.0488) (0.02, 0.198) (0.03, 0.445) (0.04, 0.78) (0.05, 1.2) (0.06, 1.6822) (0.07, 2.249) (0.08, 2.9643) (0.09, 3.6558) (0.1, 4.4062) (0.15, 9.279) (0.2, 15.55) (0.25, 23.691) (0.3, 32.867) (0.35, 44.249) (0.4, 56.288) (0.45, 69.552) (0.5, 85.8)} core_loss_curve{5kHz (0, 0) (0.01, 0.239) (0.02, 0.92) (0.03, 2.02) (0.04, 3.5) (0.05, 5.3) (0.06, 7.45) (0.07, 9.9) (0.08, 12.6) (0.09, 15.6) (0.1, 18.8) (0.15, 39.5) (0.2, 65.9) (0.25, 99)} core_loss_curve{10kHz (0, 0) (0.01, 0.7047) (0.02, 2.8) (0.03, 6.1637) (0.04, 10.5817) (0.05, 15.8004) (0.06, 21.9466) (0.07, 28.9499) (0.08, 36.8153) (0.09, 45.5366) (0.1, 55)} permeability{HUnit=A_per_meter BUnit=tesla curve (0, 0) (10, 0.02) (20, 0.054) (30, 0.097) (40, 0.18) (50, 0.32) (60, 0.515) (70, 0.683) (80, 0.82) (100, 1) (125, 1.138) (150, 1.212) (175, 1.26) (200, 1.293) (250, 1.338) (300, 1.366) (400, 1.404) (500, 1.429) (800, 1.481) (1000, 1.502) (1500, 1.542) (2000, 1.571) (2500, 1.597) (3000, 1.618) (4000, 1.657) (5000, 1.695) (8000, 1.772) (10000, 1.81) (15000, 1.881) (20000, 1.934) (30000, 1.998) (50000, 2.058) (80000, 2.104)} conductivity=1960784 core_loss_type="Electrical Steel" core_loss_kh=354.45702 core_loss_kc=0.39413798 core_loss_ke=1.7003259 mass_density=7650
  JFE_Steel_50JN350_mod_sf098: core_loss_curve{50Hz (0, 0) (0.5, 0.401) (0.55, 0.481) (0.6, 0.559) (0.65, 0.633) (0.7, 0.717) (0.75, 0.802) (0.8, 0.893) (0.85, 0.989) (0.9, 1.089) (0.95, 1.192) (1, 1.303) (1.05, 1.415) (1.1, 1.547) (1.15, 1.684) (1.2, 1.829) (1.25, 1.986) (1.3, 2.157) (1.35, 2.342) (1.4, 2.551) (1.45, 2.777) (1.5, 2.998) (1.55, 3.241) (1.6, 3.489) (1.65, 3.77) (1.7, 4.035)} core_loss_curve{60Hz (0, 0) (0.5, 0.547) (0.55, 0.629) (0.6, 0.724) (0.65, 0.819) (0.7, 0.923) (0.75, 1.036) (0.8, 1.145) (0.85, 1.263) (0.9, 1.389) (0.95, 1.52) (1, 1.659) (1.05, 1.798) (1.1, 1.967) (1.15, 2.141) (1.2, 2.331) (1.25, 2.531) (1.3, 2.757) (1.35, 2.987) (1.4, 3.229) (1.45, 3.494) (1.5, 3.782) (1.55, 4.081) (1.6, 4.4) (1.65, 4.727) (1.7, 5.07)} core_loss_curve{100Hz (0, 0) (0.06, 0.013) (0.07, 0.0189) (0.08, 0.0254) (0.09, 0.0337) (0.1, 0.0422) (0.15, 0.106) (0.2, 0.19) (0.25, 0.293) (0.3, 0.405) (0.35, 0.532) (0.4, 0.676) (0.45, 0.832) (0.5, 0.987) (0.55, 1.171) (0.6, 1.34) (0.65, 1.536) (0.7, 1.732) (0.75, 1.921) (0.8, 2.157) (0.85, 2.395) (0.9, 2.612) (0.95, 2.9) (1, 3.22) (1.1, 3.82) (1.2, 4.56) (1.3, 5.49) (1.4, 6.53) (1.5, 7.8)} core_loss_curve{200Hz (0, 0) (0.04, 0.0146) (0.05, 0.0238) (0.06, 0.0355) (0.07, 0.05) (0.08, 0.067) (0.09, 0.086) (0.1, 0.108) (0.15, 0.254) (0.2, 0.443) (0.25, 0.695) (0.3, 0.985) (0.35, 1.301) (0.4, 1.655) (0.45, 2.045) (0.5, 2.484) (0.55, 2.937) (0.6, 3.481) (0.65, 3.977) (0.7, 4.532) (0.75, 5.132) (0.8, 5.8) (0.85, 6.467) (0.9, 7.273) (0.95, 8.016) (1, 8.811) (1.1, 10.75) (1.2, 13.1) (1.3, 15.75) (1.4, 18.9) (1.5, 22.5)} core_loss_curve{400Hz (0, 0) (0.02, 0.01) (0.03, 0.024) (0.04, 0.0458) (0.05, 0.074) (0.06, 0.108) (0.07, 0.152) (0.08, 0.2008) (0.09, 0.255) (0.1, 0.3155) (0.15, 0.7159) (0.2, 1.25) (0.25, 1.903) (0.3, 2.682) (0.35, 3.555) (0.4, 4.519) (0.45, 5.583) (0.5, 6.748) (0.55, 8.01) (0.6, 9.367) (0.65, 10.849) (0.7, 12.615) (0.75, 14.284) (0.8, 16.372) (0.85, 18.258) (0.9, 20.654) (0.95, 23.23) (1, 26) (1.1, 32.15) (1.2, 39.97) (1.3, 49.07) (1.4, 59.3) (1.5, 71)} core_loss_curve{1kHz (0, 0) (0.01, 0.0132) (0.02, 0.0555) (0.03, 0.128) (0.04, 0.234) (0.05, 0.368) (0.06, 0.529) (0.07, 0.71) (0.08, 0.92) (0.09, 1.15) (0.1, 1.42) (0.15, 3) (0.2, 5.2) (0.25, 7.88) (0.3, 11.077) (0.35, 14.655) (0.4, 18.611) (0.45, 23.448) (0.5, 28.326) (0.55, 34.301) (0.6, 40.096) (0.65, 47.254) (0.7, 53.976) (0.75, 62.362) (0.8, 71.47) (0.85, 79.695) (0.9, 92)} core_loss_curve{2kHz (0, 0) (0.01, 0.0488) (0.02, 0.198) (0.03, 0.445) (0.04, 0.78) (0.05, 1.2) (0.06, 1.6822) (0.07, 2.249) (0.08, 2.9643) (0.09, 3.6558) (0.1, 4.4062) (0.15, 9.279) (0.2, 15.55) (0.25, 23.691) (0.3, 32.867) (0.35, 44.249) (0.4, 56.288) (0.45, 69.552) (0.5, 85.8)} core_loss_curve{5kHz (0, 0) (0.01, 0.239) (0.02, 0.92) (0.03, 2.02) (0.04, 3.5) (0.05, 5.3) (0.06, 7.45) (0.07, 9.9) (0.08, 12.6) (0.09, 15.6) (0.1, 18.8) (0.15, 39.5) (0.2, 65.9) (0.25, 99)} core_loss_curve{10kHz (0, 0) (0.01, 0.7047) (0.02, 2.8) (0.03, 6.1637) (0.04, 10.5817) (0.05, 15.8004) (0.06, 21.9466) (0.07, 28.9499) (0.08, 36.8153) (0.09, 45.5366) (0.1, 55)} permeability{HUnit=A_per_meter BUnit=tesla curve (0, 0) (10, 0.02) (20, 0.054) (30, 0.097) (40, 0.18) (50, 0.32) (60, 0.515) (70, 0.683) (80, 0.82) (100, 1) (125, 1.138) (150, 1.212) (175, 1.26) (200, 1.293) (250, 1.338) (300, 1.366) (400, 1.404) (500, 1.429) (800, 1.481) (1000, 1.502) (1500, 1.542) (2000, 1.571) (2500, 1.597) (3000, 1.618) (4000, 1.657) (5000, 1.695) (8000, 1.772) (10000, 1.81) (15000, 1.881) (20000, 1.934) (30000, 1.998) (50000, 2.058) (80000, 2.104)} core_loss_type="Electrical Steel" core_loss_kh=354.45702 core_loss_kc=0.39413798 core_loss_ke=1.7003259 mass_density=7650 stacking_type=Lamination stacking_factor=0.98 stacking_direction=V(3)
  JFE_Steel_50JN350_mod: core_loss_curve{50Hz (0, 0) (0.5, 0.401) (0.55, 0.481) (0.6, 0.559) (0.65, 0.633) (0.7, 0.717) (0.75, 0.802) (0.8, 0.893) (0.85, 0.989) (0.9, 1.089) (0.95, 1.192) (1, 1.303) (1.05, 1.415) (1.1, 1.547) (1.15, 1.684) (1.2, 1.829) (1.25, 1.986) (1.3, 2.157) (1.35, 2.342) (1.4, 2.551) (1.45, 2.777) (1.5, 2.998) (1.55, 3.241) (1.6, 3.489) (1.65, 3.77) (1.7, 4.035)} core_loss_curve{60Hz (0, 0) (0.5, 0.547) (0.55, 0.629) (0.6, 0.724) (0.65, 0.819) (0.7, 0.923) (0.75, 1.036) (0.8, 1.145) (0.85, 1.263) (0.9, 1.389) (0.95, 1.52) (1, 1.659) (1.05, 1.798) (1.1, 1.967) (1.15, 2.141) (1.2, 2.331) (1.25, 2.531) (1.3, 2.757) (1.35, 2.987) (1.4, 3.229) (1.45, 3.494) (1.5, 3.782) (1.55, 4.081) (1.6, 4.4) (1.65, 4.727) (1.7, 5.07)} core_loss_curve{100Hz (0, 0) (0.06, 0.013) (0.07, 0.0189) (0.08, 0.0254) (0.09, 0.0337) (0.1, 0.0422) (0.15, 0.106) (0.2, 0.19) (0.25, 0.293) (0.3, 0.405) (0.35, 0.532) (0.4, 0.676) (0.45, 0.832) (0.5, 0.987) (0.55, 1.171) (0.6, 1.34) (0.65, 1.536) (0.7, 1.732) (0.75, 1.921) (0.8, 2.157) (0.85, 2.395) (0.9, 2.612) (0.95, 2.9) (1, 3.22) (1.1, 3.82) (1.2, 4.56) (1.3, 5.49) (1.4, 6.53) (1.5, 7.8)} core_loss_curve{200Hz (0, 0) (0.04, 0.0146) (0.05, 0.0238) (0.06, 0.0355) (0.07, 0.05) (0.08, 0.067) (0.09, 0.086) (0.1, 0.108) (0.15, 0.254) (0.2, 0.443) (0.25, 0.695) (0.3, 0.985) (0.35, 1.301) (0.4, 1.655) (0.45, 2.045) (0.5, 2.484) (0.55, 2.937) (0.6, 3.481) (0.65, 3.977) (0.7, 4.532) (0.75, 5.132) (0.8, 5.8) (0.85, 6.467) (0.9, 7.273) (0.95, 8.016) (1, 8.811) (1.1, 10.75) (1.2, 13.1) (1.3, 15.75) (1.4, 18.9) (1.5, 22.5)} core_loss_curve{400Hz (0, 0) (0.02, 0.01) (0.03, 0.024) (0.04, 0.0458) (0.05, 0.074) (0.06, 0.108) (0.07, 0.152) (0.08, 0.2008) (0.09, 0.255) (0.1, 0.3155) (0.15, 0.7159) (0.2, 1.25) (0.25, 1.903) (0.3, 2.682) (0.35, 3.555) (0.4, 4.519) (0.45, 5.583) (0.5, 6.748) (0.55, 8.01) (0.6, 9.367) (0.65, 10.849) (0.7, 12.615) (0.75, 14.284) (0.8, 16.372) (0.85, 18.258) (0.9, 20.654) (0.95, 23.23) (1, 26) (1.1, 32.15) (1.2, 39.97) (1.3, 49.07) (1.4, 59.3) (1.5, 71)} core_loss_curve{1kHz (0, 0) (0.01, 0.0132) (0.02, 0.0555) (0.03, 0.128) (0.04, 0.234) (0.05, 0.368) (0.06, 0.529) (0.07, 0.71) (0.08, 0.92) (0.09, 1.15) (0.1, 1.42) (0.15, 3) (0.2, 5.2) (0.25, 7.88) (0.3, 11.077) (0.35, 14.655) (0.4, 18.611) (0.45, 23.448) (0.5, 28.326) (0.55, 34.301) (0.6, 40.096) (0.65, 47.254) (0.7, 53.976) (0.75, 62.362) (0.8, 71.47) (0.85, 79.695) (0.9, 92)} core_loss_curve{2kHz (0, 0) (0.01, 0.0488) (0.02, 0.198) (0.03, 0.445) (0.04, 0.78) (0.05, 1.2) (0.06, 1.6822) (0.07, 2.249) (0.08, 2.9643) (0.09, 3.6558) (0.1, 4.4062) (0.15, 9.279) (0.2, 15.55) (0.25, 23.691) (0.3, 32.867) (0.35, 44.249) (0.4, 56.288) (0.45, 69.552) (0.5, 85.8)} core_loss_curve{5kHz (0, 0) (0.01, 0.239) (0.02, 0.92) (0.03, 2.02) (0.04, 3.5) (0.05, 5.3) (0.06, 7.45) (0.07, 9.9) (0.08, 12.6) (0.09, 15.6) (0.1, 18.8) (0.15, 39.5) (0.2, 65.9) (0.25, 99)} core_loss_curve{10kHz (0, 0) (0.01, 0.7047) (0.02, 2.8) (0.03, 6.1637) (0.04, 10.5817) (0.05, 15.8004) (0.06, 21.9466) (0.07, 28.9499) (0.08, 36.8153) (0.09, 45.5366) (0.1, 55)} permeability{HUnit=A_per_meter BUnit=tesla curve (0, 0) (10, 0.02) (20, 0.054) (30, 0.097) (40, 0.18) (50, 0.32) (60, 0.515) (70, 0.683) (80, 0.82) (100, 1) (125, 1.138) (150, 1.212) (175, 1.26) (200, 1.293) (250, 1.338) (300, 1.366) (400, 1.404) (500, 1.429) (800, 1.481) (1000, 1.502) (1500, 1.542) (2000, 1.571) (2500, 1.597) (3000, 1.618) (4000, 1.657) (5000, 1.695) (8000, 1.772) (10000, 1.81) (15000, 1.881) (20000, 1.934) (30000, 1.998) (50000, 2.058) (80000, 2.104)} core_loss_type="Electrical Steel" core_loss_kh=354.45702 core_loss_kc=0.39413798 core_loss_ke=1.7003259 mass_density=7650 stacking_type=Solid
  Isola Chronon (tm): permittivity=3.68 dielectric_loss_tangent=0.0038
  iron_thesis: permeability=1000 conductivity=4500000
  iron_thesis_wrong: permeability=1
  cast_aluminum_75C_thesis: permeability=1.000021 conductivity=17000000

design AnsysReference (Maxwell 2D, Transient, XY geometry, model units mm)
options: ModelDepth=100mm
variables:
  Turn = 10
  Vin = 10V
  Vfreq = 50Hz
  Sync_speed = 90mm*Vfreq m_per_sec
  Slip = 0.6
  Trans_speed = (1-Slip)*Sync_speed
  Coil_R = 0.1ohm
geometry:
  LinearMCore1#6 = user_primitive(RMxprt/LinearMCore.dll, WidthCore=300mm, ThickCore=30mm, Length=100mm, Gap=0.5mm, SlotPitch=15mm, Slots=16, SlotType=2, Hs0=1mm, Hs01=0mm, Hs1=0.2mm, Hs2=12mm, Bs0=6mm, Bs1=8mm, Bs2=8mm, Rs=0mm, Layers=2, CoilPitch=3, EndExt=5mm, SpanExt=23mm, SegAngle=0deg, InfoTubular=0, InfoCore=1)
  Coil_U_1#50665, Coil_V_2#50666, Coil_W_3#50667, Coil_U_2#50668, Coil_V_3#50669, Coil_W_4#50670, Coil_U_3#50671, Coil_V_4#50672, Coil_U_4#50673, Coil_W#50674, Coil_V#50675, Coil_U#50676, Coil_W_1#50677 = LinearMCore1#6.separate_bodies()
  Plate#57484 = box(corner=(-300mm, 0mm, -50mm), size=(600mm, -2mm, 100mm))
  Plate1 = box(corner=(-300mm, -2mm, -50mm), size=(600mm, -13mm, 100mm))
  Region#57540 = box(corner=(-300mm, -15mm, -100mm), size=(600mm, 60mm, 200mm))
  Bnad#67412 = box(corner=(-300mm, 0mm, -100mm), size=(600mm, 45mm, 200mm))
  Inner_Region#67440 = box(corner=(-300mm, 0.25mm, -100mm), size=(600mm, (45-0.25) mm, 200mm))
  LinearMCore1 [JFE_Steel_50JN350_mod] = LinearMCore1#6.section(plane=XY)
  LinearMCore1#6.delete()
  Coil_U_1 [copper] = Coil_U_1#50665.section(plane=XY)
  Coil_U_1#50665.delete()
  Coil_V_2 [copper] = Coil_V_2#50666.section(plane=XY)
  Coil_V_2#50666.delete()
  Coil_W_3 [copper] = Coil_W_3#50667.section(plane=XY)
  Coil_W_3#50667.delete()
  Coil_U_2 [copper] = Coil_U_2#50668.section(plane=XY)
  Coil_U_2#50668.delete()
  Coil_V_3 [copper] = Coil_V_3#50669.section(plane=XY)
  Coil_V_3#50669.delete()
  Coil_W_4 [copper] = Coil_W_4#50670.section(plane=XY)
  Coil_W_4#50670.delete()
  Coil_U_3 [copper] = Coil_U_3#50671.section(plane=XY)
  Coil_U_3#50671.delete()
  Coil_V_4 [copper] = Coil_V_4#50672.section(plane=XY)
  Coil_V_4#50672.delete()
  Coil_U_4 [copper] = Coil_U_4#50673.section(plane=XY)
  Coil_U_4#50673.delete()
  Coil_W [copper] = Coil_W#50674.section(plane=XY)
  Coil_W#50674.delete()
  Coil_V [copper] = Coil_V#50675.section(plane=XY)
  Coil_V#50675.delete()
  Coil_U [copper] = Coil_U#50676.section(plane=XY)
  Coil_U#50676.delete()
  Coil_W_1 [copper] = Coil_W_1#50677.section(plane=XY)
  Coil_W_1#50677.delete()
  Plate [cast_aluminum_75C] = Plate#57484.section(plane=XY)
  Plate#57484.delete()
  Yoke [iron] = Plate1.section(plane=XY)
  Plate1.delete()
  Region [vacuum] = Region#57540.section(plane=XY)
  Region#57540.delete()
  Bnad [vacuum] = Bnad#67412.section(plane=XY)
  Bnad#67412.delete()
  Inner_Region [vacuum] = Inner_Region#67440.section(plane=XY)
  Inner_Region#67440.delete()
  Coil_U_Separate1 [copper] = Coil_U.separate_bodies()
  Coil_U_1_Separate1 [copper] = Coil_U_1.separate_bodies()
  Coil_U_2_Separate1 [copper] = Coil_U_2.separate_bodies()
  Coil_U_3_Separate1 [copper] = Coil_U_3.separate_bodies()
  Coil_U_4_Separate1 [copper] = Coil_U_4.separate_bodies()
  Coil_V_Separate1 [copper] = Coil_V.separate_bodies()
  Coil_V_2_Separate1 [copper] = Coil_V_2.separate_bodies()
  Coil_V_3_Separate1 [copper] = Coil_V_3.separate_bodies()
  Coil_V_4_Separate1 [copper] = Coil_V_4.separate_bodies()
  Coil_W_Separate1 [copper] = Coil_W.separate_bodies()
  Coil_W_1_Separate1 [copper] = Coil_W_1.separate_bodies()
  Coil_W_3_Separate1 [copper] = Coil_W_3.separate_bodies()
  Coil_W_4_Separate1 [copper] = Coil_W_4.separate_bodies()
  Dummy1 [vacuum] = rectangle(corner=(-150mm, 0.5mm, 0mm), x_size=300mm, y_size=30mm)
  LinearMCore1.separate_bodies()
motion:
  MotionSetup1: Band Move_Type=Translate Coordinate_System=Global PostProcessing_Coordinate_System=Global Axis=X Is_Positive=true InitPos=0mm TranslatePeriodic Velocity=Trans_speed Objects=Bnad
  Moving1: Moving Objects=[LinearMCore1, Coil_U_1, Coil_V_2, Coil_W_3, Coil_U_2, Coil_V_3, Coil_W_4, Coil_U_3, Coil_V_4, Coil_U_4, Coil_W, Coil_V, Coil_U, Coil_W_1, Inner_Region, Coil_U_Separate1, Coil_U_1_Separate1, Coil_U_2_Separate1, Coil_U_3_Separate1, Coil_U_4_Separate1, Coil_V_Separate1, Coil_V_2_Separate1, Coil_V_3_Separate1, Coil_V_4_Separate1, Coil_W_Separate1, Coil_W_1_Separate1, Coil_W_3_Separate1, Coil_W_4_Separate1, Dummy1]
boundaries and excitations:
  Master1: Independent Edges=Region.edge(at (-300, 15, 0))
  Slave1: Dependent Edges=Region.edge(at (300, 15, 0)) ReverseU Independent=Master1 SameAsMaster=true
  VectorPotential1: Vector Potential Edges=Region.edge(at (0, 45, 0), at (0, -15, 0)) Value=0
  Coil_U: Coil Objects=Coil_U Conductor_number=Turn Winding=Phase_U PolarityType=Positive
  Coil_U_2_Separate1: Coil Objects=Coil_U_2_Separate1 Conductor_number=Turn Winding=Phase_U PolarityType=Positive
  Coil_U_1_Separate1: Coil Objects=Coil_U_1_Separate1 Conductor_number=Turn Winding=Phase_U PolarityType=Positive
  Coil_U_3_Separate1: Coil Objects=Coil_U_3_Separate1 Conductor_number=Turn Winding=Phase_U PolarityType=Positive
  Coil_U_4: Coil Objects=Coil_U_4 Conductor_number=Turn Winding=Phase_U PolarityType=Positive
  Coil_U_Separate1: Coil Objects=Coil_U_Separate1 Conductor_number=Turn Winding=Phase_U PolarityType=Negative
  Coil_U_1: Coil Objects=Coil_U_1 Conductor_number=Turn Winding=Phase_U PolarityType=Negative
  Coil_U_4_Separate1: Coil Objects=Coil_U_4_Separate1 Conductor_number=Turn Winding=Phase_U PolarityType=Negative
  Coil_U_2: Coil Objects=Coil_U_2 Conductor_number=Turn Winding=Phase_U PolarityType=Negative
  Coil_U_3: Coil Objects=Coil_U_3 Conductor_number=Turn Winding=Phase_U PolarityType=Negative
  Coil_W_1: Coil Objects=Coil_W_1 Conductor_number=Turn Winding=Phase_W PolarityType=Positive
  Coil_W_3_Separate1: Coil Objects=Coil_W_3_Separate1 Conductor_number=Turn Winding=Phase_W PolarityType=Positive
  Coil_W_4_Separate1: Coil Objects=Coil_W_4_Separate1 Conductor_number=Turn Winding=Phase_W PolarityType=Positive
  Coil_W: Coil Objects=Coil_W Conductor_number=Turn Winding=Phase_W PolarityType=Positive
  Coil_W_4: Coil Objects=Coil_W_4 Conductor_number=Turn Winding=Phase_W PolarityType=Negative
  Coil_W_1_Separate1: Coil Objects=Coil_W_1_Separate1 Conductor_number=Turn Winding=Phase_W PolarityType=Negative
  Coil_W_Separate1: Coil Objects=Coil_W_Separate1 Conductor_number=Turn Winding=Phase_W PolarityType=Negative
  Coil_W_3: Coil Objects=Coil_W_3 Conductor_number=Turn Winding=Phase_W PolarityType=Negative
  Coil_V_2_Separate1: Coil Objects=Coil_V_2_Separate1 Conductor_number=Turn Winding=Phase_V PolarityType=Positive
  Coil_V_3_Separate1: Coil Objects=Coil_V_3_Separate1 Conductor_number=Turn Winding=Phase_V PolarityType=Positive
  Coil_V: Coil Objects=Coil_V Conductor_number=Turn Winding=Phase_V PolarityType=Positive
  Coil_V_4: Coil Objects=Coil_V_4 Conductor_number=Turn Winding=Phase_V PolarityType=Positive
  Coil_V_Separate1: Coil Objects=Coil_V_Separate1 Conductor_number=Turn Winding=Phase_V PolarityType=Negative
  Coil_V_2: Coil Objects=Coil_V_2 Conductor_number=Turn Winding=Phase_V PolarityType=Negative
  Coil_V_4_Separate1: Coil Objects=Coil_V_4_Separate1 Conductor_number=Turn Winding=Phase_V PolarityType=Negative
  Coil_V_3: Coil Objects=Coil_V_3 Conductor_number=Turn Winding=Phase_V PolarityType=Negative
  Phase_U: Winding Group Type=Voltage IsSolid=false Current=0A Resistance=Coil_R Inductance=0mH Voltage=Vin*sin(2*pi*Vfreq*Time) ParallelBranchesNum=1
  Phase_W: Winding Group Type=Voltage IsSolid=false Current=0A Resistance=Coil_R Inductance=0mH Voltage=Vin*sin(2*pi*Vfreq*Time-2/3*pi) ParallelBranchesNum=1
  Phase_V: Winding Group Type=Voltage IsSolid=false Current=0A Resistance=Coil_R Inductance=0mH Voltage=Vin*sin(2*pi*Vfreq*Time+2/3*pi) ParallelBranchesNum=1
  eddy effects on: Plate
  core loss on: LinearMCore1
mesh:
  SkinDepth1: SkinDepthLayers Edges=Plate.edge(at (0, 0, 0)) SkinDepth=1.5mm NumLayers=3 NumMaxElem=1000 SurfTriMaxLength=120mm
  Core: LengthBased RefineInside Objects=LinearMCore1 MaxLength=4mm
  Slot_Areta: LengthBased RefineInside Objects=Dummy1 MaxLength=3mm
  Coils: LengthBased RefineInside Objects=[Coil_U, Coil_U_1, Coil_U_1_Separate1, Coil_U_2, Coil_U_2_Separate1, Coil_U_3, Coil_U_3_Separate1, Coil_U_4, Coil_U_4_Separate1, Coil_U_Separate1, Coil_W, Coil_W_1, Coil_W_1_Separate1, Coil_W_3, Coil_W_3_Separate1, Coil_W_4, Coil_W_4_Separate1, Coil_W_Separate1, Coil_V, Coil_V_2, Coil_V_2_Separate1, Coil_V_3, Coil_V_3_Separate1, Coil_V_4, Coil_V_4_Separate1, Coil_V_Separate1] MaxLength=5mm
  Yoke: LengthBased RefineInside Objects=Yoke MaxLength=5mm
  initial mesh: GlobalSurfApproximation{CurvedSurfaceApproxChoice=UseSlider SliderMeshSettings=8} MeshMethod=AnsoftTAU
setups:
  Setup1: Transient NonlinearSolverResidual=0.0001 SmoothBHCurve StopTime=1/Vfreq*10 TimeStep=1/Vfreq/50 FastReachSteadyState FrequencyOfAddedVoltageSource=Vfreq SaveFieldsType=Custom SweepRanges{0s to 0.02s step 0.002s} NumberSolveSteps=1 RangeStart=0s RangeEnd=0.1s InitialTimeStep=0.002s MinTimeStep=0.001s MaxTimeStep=0.003s TimeStepErrTolerance=0.0001
output variables:
  Output_Power = Moving1.Force_x*Moving1.Speed
  Input_Power = InputVoltage(Phase_U)*Current(Phase_U)+InputVoltage(Phase_V)*Current(Phase_V)+InputVoltage(Phase_W)*Current(Phase_W)
  Copper_Loss = Coil_R*Current(Phase_U)^2+Coil_R*Current(Phase_V)^2+Coil_R*Current(Phase_W)^2
field plots:
  Mesh1: MeshPlots over a plane on Setup1 : Transient at Time=-1
  Mag_B1, B_Vector1: B over a plane on Setup1 : Transient at Time=-1
  Jz1, J_Vector1: J over Plate on Setup1 : Transient at Time=-1
  Flux_Lines1: A over a plane on Setup1 : Transient at Time=-1
  Total_Loss1: Total-Loss over LinearMCore1 on Setup1 : Transient at Time=-1
  Total_Loss2: Total-Loss2 over Plate on Setup1 : Transient at Time=-1
reports:
  Force Plot 1: Moving1.Force_x, Moving1.Force_y vs Time on Setup1 : Transient
  Position Plot 1: Moving1.Position vs Time on Setup1 : Transient; markers MX1 at x=0.02
  Loss Plot 1: CoreLoss, SolidLoss, Copper_Loss vs Time on Setup1 : Transient
  FluxLinkage: FluxLinkage(Phase_U), FluxLinkage(Phase_V), FluxLinkage(Phase_W) vs Time on Setup1 : Transient
  Induced Voltage: InducedVoltage(Phase_U), InducedVoltage(Phase_V), InducedVoltage(Phase_W) vs Time on Setup1 : Transient
  Input Voltage: InputVoltage(Phase_U), InputVoltage(Phase_V), InputVoltage(Phase_W) vs Time on Setup1 : Transient
  Current: Current(Phase_U), Current(Phase_V), Current(Phase_W) vs Time on Setup1 : Transient
  Output Variables Plot 1: Output_Power, Input_Power vs Time on Setup1 : Transient; markers MX1 at x=0.1
  Force X Plot 2: Moving1.Force_x vs Time on Setup1 : Transient

design ThesisImplementation (Maxwell 2D, Transient, XY geometry, model units mm)
options: ModelDepth=coreDepth
variables:
  Turn = 57
  Vfreq = 100Hz
  Sync_speed = 2*Vfreq*polePitch m_per_sec
  Slip = 1
  Trans_speed = (1-Slip)*Sync_speed
  coreLength = 268mm
  coreHeight = yokeHeight + slotHeight
  coreDepth = 50mm
  slotHeight = 20mm
  slotWidth = 10mm
  toothWidth = 6mm
  slotPitch = slotWidth + toothWidth
  polePitch = coreLength/poles
  q = slots/poles/phaseCount
  slots = 16
  poles = 6
  phaseCount = 3
  airGap = 2.7mm
  aluminumHeight = 2mm
  backIronHeight = 8mm
  yokeHeight = (SlotPitch - SlotWidth)*4*0 + 6.5mm
  coilPitch = 2
  modelLength = 525 + 0 * 12 * (slotPitch * phaseCount) mm
  Ipeak = 10A
  Coil_R = copperResistivity*wireLength/wireArea ohm
  copperResistivity = (1.77*10^-8) Ohmm
  wireLength = coilLength*coilsPerPhase*Turn meter
  slotArea = slotHeight*slotWidth m2
  wireArea = slotArea/Turn m2
  coilsPerPhase = 4
  coilLength = 1.25*2*sqrt((slotPitch*coilPitch)^2 + (slotHeight/2)^2) meter
  Vpeak = 10V
  coilBuffer = 0.1
geometry:
  BackIron [iron_thesis] = rectangle(corner=(-(modelLength/2), -(aluminumHeight+backIronHeight), 0mm), x_size=modelLength, y_size=backIronHeight)
  Rotor [cast_aluminum_75C_thesis] = rectangle(corner=(-(modelLength/2), 0mm, 0mm), x_size=modelLength, y_size=-aluminumHeight)
  InnerRegion [vacuum] = rectangle(corner=(-(modelLength/2), airGap/2, 0mm), x_size=modelLength, y_size=coreHeight*1.5)
  Band [vacuum] = rectangle(corner=(-(modelLength/2), 0mm, 0mm), x_size=modelLength, y_size=airGap/2 + coreHeight*1.5)
  MotorRegion [vacuum] = rectangle(corner=(-134mm, airGap, 0mm), x_size=coreLength, y_size=coreHeight)
  Region [vacuum] = region(percentage_offset: +X=0, -X=0, +Y=0, -Y=20, +Z=0, -Z=0)
  LinearMCore [vacuum, non-model] = user_primitive(RMxprt/LinearMCore.dll, WidthCore=coreLength, ThickCore=coreHeight, Length=coreDepth, Gap=airGap, SlotPitch=slotPitch, Slots=slots, SlotType=3, Hs0=0mm, Hs01=0mm, Hs1=0mm, Hs2=slotHeight, Bs0=0mm, Bs1=slotWidth, Bs2=0mm, Rs=0mm, Layers=2, CoilPitch=coilPitch, EndExt=5mm, SpanExt=20mm, SegAngle=15deg, InfoTubular=0, InfoCore=0)
  LinearMCore_Section [iron_thesis] = LinearMCore.section(plane=XY)
  CoilB1 = rectangle(corner=((-slots * slotPitch + toothWidth + coilBuffer*slotWidth)/2, (slotHeight + coilBuffer*slotWidth)/2 + airGap, 0mm), x_size=(1 - coilBuffer) * slotWidth, y_size=(1 - coilBuffer)*slotHeight / 2)
  CoilA1_ = rectangle(corner=((-slots * slotPitch + toothWidth + coilBuffer * slotWidth) / 2, airGap + coilBuffer * slotWidth / 2, 0mm), x_size=(1 - coilBuffer) * slotWidth, y_size=(1 - coilBuffer) * slotHeight / 2)
  CoilA1, CoilC1, CoilB2, CoilA2, CoilC2, CoilB3, CoilA3, CoilC3, CoilB4, CoilA4, CoilC4, CoilB5 [copper] = CoilB1.duplicate_along_line(step=(16mm, 0mm, 0mm), total=16)  # copies kept: 1..12
  CoilB1.delete()
  CoilA2_, CoilC2_, CoilB2_, CoilA3_, CoilC3_, CoilB3_, CoilA4_, CoilC4_, CoilB4_, CoilA5_, CoilC5_, CoilB5_ [copper] = CoilA1_.duplicate_along_line(step=(16mm, 0mm, 0mm), total=16)  # copies kept: 3..14
  CoilA1_.delete()
  MiddleAirgap = polyline((-(modelLength/2), airGap/2, 0mm) ((modelLength/2), airGap/2, 0mm))
motion:
  MotionSetup1: Band Move_Type=Translate Coordinate_System=Global PostProcessing_Coordinate_System=Global Axis=X Is_Positive=true InitPos=0mm TranslatePeriodic Velocity=Trans_speed Objects=Band
  Moving1: Moving Objects=[InnerRegion, MotorRegion, LinearMCore_Section, CoilA1, CoilC1, CoilB2, CoilA2, CoilC2, CoilB3, CoilA3, CoilC3, CoilB4, CoilA4, CoilC4, CoilB5, CoilA2_, CoilC2_, CoilB2_, CoilA3_, CoilC3_, CoilB3_, CoilA4_, CoilC4_, CoilB4_, CoilA5_, CoilC5_, CoilB5_, MiddleAirgap]
boundaries and excitations:
  Parent: Independent Edges=Region.edge(3 of 4)
  Child: Dependent Edges=Region.edge(1 of 4) ReverseU Independent=Parent SameAsMaster=true
  Non-periodic: Vector Potential Edges=Region.edge(4 of 4, 2 of 4) Value=0
  CoilA1: Coil Objects=CoilA1 Conductor_number=Turn Winding=PhaseA PolarityType=Positive
  CoilA1_: Coil Objects=CoilA2 Conductor_number=Turn Winding=PhaseA PolarityType=Negative
  CoilA2: Coil Objects=CoilA2_ Conductor_number=Turn Winding=PhaseA PolarityType=Positive
  CoilA3: Coil Objects=CoilA3 Conductor_number=Turn Winding=PhaseA PolarityType=Positive
  CoilA2_: Coil Objects=CoilA3_ Conductor_number=Turn Winding=PhaseA PolarityType=Negative
  CoilA3_: Coil Objects=CoilA4 Conductor_number=Turn Winding=PhaseA PolarityType=Negative
  CoilA4: Coil Objects=CoilA4_ Conductor_number=Turn Winding=PhaseA PolarityType=Positive
  CoilA4_: Coil Objects=CoilA5_ Conductor_number=Turn Winding=PhaseA PolarityType=Negative
  CoilB1: Coil Objects=CoilB2 Conductor_number=Turn Winding=PhaseB PolarityType=Positive
  CoilB2: Coil Objects=CoilB2_ Conductor_number=Turn Winding=PhaseB PolarityType=Positive
  CoilB1_: Coil Objects=CoilB3 Conductor_number=Turn Winding=PhaseB PolarityType=Negative
  CoilB2_: Coil Objects=CoilB3_ Conductor_number=Turn Winding=PhaseB PolarityType=Negative
  CoilB3: Coil Objects=CoilB4 Conductor_number=Turn Winding=PhaseB PolarityType=Positive
  CoilB4: Coil Objects=CoilB4_ Conductor_number=Turn Winding=PhaseB PolarityType=Positive
  CoilB3_: Coil Objects=CoilB5 Conductor_number=Turn Winding=PhaseB PolarityType=Negative
  CoilB4_: Coil Objects=CoilB5_ Conductor_number=Turn Winding=PhaseB PolarityType=Negative
  CoilC1_: Coil Objects=CoilC1 Conductor_number=Turn Winding=PhaseC PolarityType=Negative
  CoilC1: Coil Objects=CoilC2 Conductor_number=Turn Winding=PhaseC PolarityType=Positive
  CoilC2_: Coil Objects=CoilC2_ Conductor_number=Turn Winding=PhaseC PolarityType=Negative
  CoilC3_: Coil Objects=CoilC3 Conductor_number=Turn Winding=PhaseC PolarityType=Negative
  CoilC2: Coil Objects=CoilC3_ Conductor_number=Turn Winding=PhaseC PolarityType=Positive
  CoilC3: Coil Objects=CoilC4 Conductor_number=Turn Winding=PhaseC PolarityType=Positive
  CoilC4_: Coil Objects=CoilC4_ Conductor_number=Turn Winding=PhaseC PolarityType=Negative
  CoilC4: Coil Objects=CoilC5_ Conductor_number=Turn Winding=PhaseC PolarityType=Positive
  PhaseA: Winding Group Type=Current IsSolid=false Current=Ipeak*sin(2*pi*Vfreq*Time) ParallelBranchesNum=1
  PhaseB: Winding Group Type=Current IsSolid=false Current=Ipeak*sin(2*pi*Vfreq*Time+2/3*pi) ParallelBranchesNum=1
  PhaseC: Winding Group Type=Current IsSolid=false Current=Ipeak*sin(2*pi*Vfreq*Time-2/3*pi) ParallelBranchesNum=1
  eddy effects on: Rotor
mesh:
  Coils: LengthBased RefineInside Objects=[CoilA1, CoilA2, CoilA2_, CoilA3, CoilA3_, CoilA4, CoilA4_, CoilA5_, CoilB2, CoilB2_, CoilB3, CoilB3_, CoilB4, CoilB4_, CoilB5, CoilB5_, CoilC1, CoilC2, CoilC2_, CoilC3, CoilC3_, CoilC4, CoilC4_, CoilC5_] MaxLength=2mm
  Core: LengthBased RefineInside Objects=LinearMCore_Section MaxLength=2mm
  BackIron: LengthBased RefineInside Objects=BackIron MaxLength=2mm
  SkinDepth: SkinDepthLayers Edges=Rotor.edge(y at corner) SkinDepth=1mm NumLayers=3 NumMaxElem=1000 SurfTriMaxLength=115.2mm
  Air: LengthBased RefineInside Objects=Band MaxLength=2mm
  initial mesh: MeshMethod=AnsoftTAU
setups:
  Setup1: Transient NonlinearSolverResidual=0.0001 SmoothBHCurve StopTime=1/Vfreq*6 TimeStep=1/Vfreq/20 SaveFieldsType=Custom SweepRanges{0s to 0.02s step 0.002s} NumberSolveSteps=1 RangeStart=0s RangeEnd=0.1s InitialTimeStep=0.002s MinTimeStep=0.001s MaxTimeStep=0.003s TimeStepErrTolerance=0.0001
output variables:
  Output_Power = Moving1.Force_x*Moving1.Speed
  Input_Power = InputVoltage(Phase_U)*Current(Phase_U)+InputVoltage(Phase_V)*Current(Phase_V)+InputVoltage(Phase_W)*Current(Phase_W)
  Copper_Loss = Coil_R*Current(Phase_U)^2+Coil_R*Current(Phase_V)^2+Coil_R*Current(Phase_W)^2
field calculator expressions:
  Btangential = Fundamental_Quantity(22) | ScalarX
  Bnormal = Fundamental_Quantity(22) | ScalarY
field plots:
  Flux_Lines1: A over a plane on Setup1 : Transient at Time=-1
  B_Vector1: B over a plane on Setup1 : Transient at Time=-1
  Mesh1: MeshPlots over BackIron, Rotor, InnerRegion, Band, MotorRegion, Region, LinearMCore_Section, CoilA1, CoilC1, CoilB2, CoilA2, CoilC2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 on Setup1 : Transient at Time=0s
  Mag_B1: B over LinearMCore_Section on Setup1 : Transient at Time=-1
reports:
  Force Plot 1: Moving1.Force_x, Moving1.Force_y vs Time on Setup1 : Transient
  Position Plot 1: Moving1.Position vs Time on Setup1 : Transient; markers MX1 at x=0.02
  Loss Plot 1: CoreLoss, SolidLoss, Copper_Loss vs Time on Setup1 : Transient
  Output Variables Plot 1: Output_Power, Input_Power vs Time on Setup1 : Transient; markers MX1 at x=0.1
  Force X Plot 2: Moving1.Force_x vs Time on Setup1 : Transient
  FluxLinkage: FluxLinkage(PhaseA), FluxLinkage(PhaseB), FluxLinkage(PhaseC) vs Time on Setup1 : Transient
  InputCurrent: InputCurrent(PhaseA), InputCurrent(PhaseB), InputCurrent(PhaseC) vs Time on Setup1 : Transient
  InducedVoltage: InducedVoltage(PhaseA), InducedVoltage(PhaseB), InducedVoltage(PhaseC) vs Time on Setup1 : Transient
  InputVoltage: InputVoltage(PhaseA), InputVoltage(PhaseB), InputVoltage(PhaseC) vs Time on Setup1 : Transient
  WindingCurrent: Current(PhaseA), Current(PhaseB), Current(PhaseC) vs Time on Setup1 : Transient
  Airgap Plot: Btangential, Bnormal vs Distance on Setup1 : Transient [Time=6e+07ns]
